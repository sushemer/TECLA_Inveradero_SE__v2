**
*$
*TPS63020
*****************************************************************************
* (C) Copyright 2010 Texas Instruments Incorporated. All rights reserved.
*****************************************************************************
** This model is designed as an aid for customers of Texas Instruments.
** TI and its licensors and suppliers make no warranties, either expressed
** or implied, with respect to this model, including the warranties of
** merchantability or fitness for a particular purpose. The model is
** provided solely on an "as is" basis. The entire risk as to its quality
** and performance is with the customer
*****************************************************************************
*
** Released by: Analog eLab Design Center, Texas Instruments Inc.
* Part: TPS63020
* Date: APR/09/2010
* Model Type: Transient
* Simulator: PSpice
* Simulator Version: 16.0.0.p001
* EVM Order Number: TPS63020EVM-487
* EVM Users Guide: SLVU365 - March 2010
* Datasheet: SLVS916 - April 2010
* Model Version: 1.0
*
*****************************************************************************
*
* Updates:
*
* Final 1.00
* Release to Web.
*
***************************************************************************
* Proteus 8.13 adaptation of TI SLIM135A for the greenhouse node.
* Interface: OUT, PGND, VIN, GND. The project ties both returns together.
* The flattened network preserves the TI transient regulator core.
* Subcircuit parameters were resolved, ABM sources translated and PSpice
* voltage-controlled switches expressed as smooth conductances.
* The test bench includes a staged VIN/EN startup and a 330-ohm output load.
* Input/output capacitors and feedback follow the 3.3-V example (Fig. 28).
.MODEL D_D1 D( IS=1e-15 TT=10p Rs=0.05 N=.1  )
.SUBCKT TPS63020_NODE13 OUT RET IN SENSE_RET
VZ1_ENSTART Z1_START SENSE_RET PULSE(0 1 100u 10u 10u 100 200)
BZ1_EN Z1_EN SENSE_RET V=(V(Z1_POWERIN)-V(SENSE_RET))*(V(Z1_START)-V(SENSE_RET))
VZ1_TEST Z1_CTRL RET DC 0 PULSE(0 1 20u 10u 1u 100 200)
BZ1_TEST IN Z1_POWERIN I=(V(IN)-V(Z1_POWERIN))*(1e-8+100*(V(Z1_CTRL)-V(RET)))
RZ2__R10 0 RET 1m
BZ2_E_ABM5 Z2_N6067255 0 V=(limit(1e5*((V(Z1_EN) )-( 1.19))+0.5,0,1)*(1))
RZ2__R11 0 SENSE_RET 1m
RZ2__R8 Z2_N6067255 Z2_ENLOGIC 1
BZ2_E_GAIN1 Z2_VIN_BUF 0 V=1 * V(Z1_POWERIN)
CZ2__C7 0 Z2_ENLOGIC 1n
BZ3_GQ 0 Z3_QINT I=(((limit(1e5*((V(Z2_CLK))-(0.5))+0.5,0,1)*(5)))+limit(1e5*((V(Z2_U1_N175129) )-( 0.5))+0.5,0,1)*((-5)-((limit(1e5*((V(Z2_CLK))-(0.5))+0.5,0,1)*(5)))))
CZ3_Qint Z3_QINT 0 1n
RZ3_Qint Z3_QINT 0 1000MEG
DZ3__D10 Z3_QINT Z3_MY5 D_D1
VZ3_1 Z3_MY5 0 1
DZ3__D11 Z3_MYVSS Z3_QINT D_D1
VZ3_2 Z3_MYVSS 0 0
EZ3_Q Z3_QQQ 0 Z3_QINT 0 1
BZ4_E_ABMGATE Z4_YINT 0 V=(limit(1e5*((V(Z3_QQQ) )-( 0.5))+0.5,0,1)*(1))
RZ4_INT Z4_YINT Z3_QQQD1 1
CZ4_INT Z3_QQQD1 0 1n
RZ3_Qq Z3_QQQD1 Z2_BOOSTDRV 1
BZ3_EQb Z3_QBR 0 V=((1-limit(1e5*((V(Z2_BOOSTDRV) )-( 0.5))+0.5,0,1))*(1))
RZ3_Qb Z3_QBR Z2_U1_N176948 1
CZ3_dummy1 Z2_BOOSTDRV 0 1n
CZ3_dummy2 Z2_U1_N176948 0 1n
.IC V(Z3_QINT)=0
BZ5_E_ABMGATE Z5_YINT 0 V=((limit(1e5*((V(Z2_U1_N185976) )-( 500E-3))+0.5,0,1)*limit(1e5*((V(Z2_BOOSTDRV) )-( 500E-3))+0.5,0,1))*(1))
RZ5_INT Z5_YINT Z2_U1_N186143 1
CZ5_INT Z2_U1_N186143 0 1n
BZ6_E_ABMGATE Z6_YINT 0 V=((1-(1-limit(1e5*((V(Z2_U1_N186143) )-( 500E-3))+0.5,0,1))*(1-limit(1e5*((V(Z2_U1_N171118) )-( 500E-3))+0.5,0,1)))*(1))
RZ6_INT Z6_YINT Z2_U1_N174794 1
CZ6_INT Z2_U1_N174794 0 1n
BZ7_E_ABM Z7_YINT 0 V=(limit(1e5*((V(Z2_BUCKRAMP) )-( V(Z2_VCA)))+0.5,0,1)*(1))
RZ7_1 Z7_YINT Z2_U1_N185976 1
CZ7_1 Z2_U1_N185976 0 1n
RZ2__U1_R1 0 Z2_U1_N176597 10k
BZ8_E_ABMGATE Z8_YINT 0 V=((1-limit(1e5*((V(Z2_PSOFF_N) )-( 500E-3))+0.5,0,1))*(1))
RZ8_INT Z8_YINT Z2_U1_N170632 1
CZ8_INT Z2_U1_N170632 0 1n
BZ9_E_ABMGATE Z9_YINT 0 V=((limit(1e5*((V(Z2_U1_N185413) )-( 500E-3))+0.5,0,1)*limit(1e5*((V(Z2_BUCKDRV) )-( 500E-3))+0.5,0,1))*(1))
RZ9_INT Z9_YINT Z2_U1_N184433 1
CZ9_INT Z2_U1_N184433 0 1n
BZ10_E_ABM Z10_YINT 0 V=(limit(1e5*((V(Z2_VCA) )-( V(Z2_BOOSTRAMP)))+0.5,0,1)*(1))
RZ10_1 Z10_YINT Z2_U1_N185413 1
CZ10_1 Z2_U1_N185413 0 1n
BZ11_GQ 0 Z11_QINT I=(((limit(1e5*((V(Z2_CLK))-(0.5))+0.5,0,1)*(5)))+limit(1e5*((V(Z2_U1_N174794) )-( 0.5))+0.5,0,1)*((-5)-((limit(1e5*((V(Z2_CLK))-(0.5))+0.5,0,1)*(5)))))
CZ11_Qint Z11_QINT 0 1n
RZ11_Qint Z11_QINT 0 1000MEG
DZ11__D10 Z11_QINT Z11_MY5 D_D1
VZ11_1 Z11_MY5 0 1
DZ11__D11 Z11_MYVSS Z11_QINT D_D1
VZ11_2 Z11_MYVSS 0 0
EZ11_Q Z11_QQQ 0 Z11_QINT 0 1
BZ12_E_ABMGATE Z12_YINT 0 V=(limit(1e5*((V(Z11_QQQ) )-( 0.5))+0.5,0,1)*(1))
RZ12_INT Z12_YINT Z11_QQQD1 1
CZ12_INT Z11_QQQD1 0 1n
RZ11_Qq Z11_QQQD1 Z2_BUCKDRV 1
BZ11_EQb Z11_QBR 0 V=((1-limit(1e5*((V(Z2_BUCKDRV) )-( 0.5))+0.5,0,1))*(1))
RZ11_Qb Z11_QBR Z2_U1_N176597 1
CZ11_dummy1 Z2_BUCKDRV 0 1n
CZ11_dummy2 Z2_U1_N176597 0 1n
.IC V(Z11_QINT)=0
RZ2__U1_R2 0 Z2_U1_N176948 10k
BZ13_E_ABMGATE Z13_YINT 0 V=((1-(1-limit(1e5*((V(Z2_U1_N184433) )-( 500E-3))+0.5,0,1))*(1-limit(1e5*((V(Z2_U1_N171118) )-( 500E-3))+0.5,0,1)))*(1))
RZ13_INT Z13_YINT Z2_U1_N175129 1
CZ13_INT Z2_U1_N175129 0 1n
BZ14_E_ABMGATE Z14_YINT 0 V=((1-(1-limit(1e5*((V(Z2_U1_N170632) )-( 500E-3))+0.5,0,1))*(1-limit(1e5*((V(Z2_FAULT) )-( 500E-3))+0.5,0,1)))*(1))
RZ14_INT Z14_YINT Z2_U1_N171118 1
CZ14_INT Z2_U1_N171118 0 1n
BZ15_S_S1 Z15_MEAS 0 I=V(Z15_MEAS)*exp(-20.7232658369+20.7232658369*(limit((V(Z15_RESET2)-0.25)/0.5,0,1))^2*(3-2*(limit((V(Z15_RESET2)-0.25)/0.5,0,1))))
BZ15_E_ABM1 Z15_CH 0 V=((1-(1-limit(1e5*((V(Z2_U2_N16667136))-(0.5))+0.5,0,1))*(1-limit(1e5*((V(Z2_U2_N16667346))-(0.5))+0.5,0,1)))*(1))
RZ15__R2 Z15_RESET2 Z15_RESET 0.1
BZ15_E_ABM3 Z2_U2_N16667346 0 V=((limit(1e5*((0.5)-(V(Z15_MEAS)))+0.5,0,1)*limit(1e5*((V(Z15_CH))-(0.5))+0.5,0,1))*(1))
RZ15__R1 Z15_MEAS Z15_CH 20
CZ15__C2 0 Z15_RESET2 1.4427n
CZ15__C1 0 Z15_MEAS 1.4427n
BZ15_E_ABM2 Z15_RESET 0 V=(limit(1e5*((0.5)-(V(Z15_CH)))+0.5,0,1)*(1))
CZ2__U2_C2 0 Z2_U2_N126109 1n IC=0
EZ2__U2_E2 Z2_U2_N16588429 Z2_U2_N128582 Z2_V3 0 1
GZ2__U2_G1 Z2_U2_N16663404 Z2_U2_N124395 Z2_VIN_BUF 0 0.84m
BZ16_S_U2_S4 Z2_U2_N16667046 0 I=(V(Z2_U2_N16667046)-V(0))*exp(-16.118095651+23.0258509299*(limit(((V(Z2_U2_N16667168)-V(0))-0.2)/0.3,0,1))^2*(3-2*(limit(((V(Z2_U2_N16667168)-V(0))-0.2)/0.3,0,1))))
RZ16_S_U2_S4 Z2_U2_N16667168 0 1G
BZ2_E_U2_GAIN2 Z2_U2_N128582 0 V=-1 * V(Z2_U2_N126109)
BZ17_E_ABMGATE Z17_YINT 0 V=((1-(1-limit(1e5*((V(Z2_U2_N16666872) )-( 500E-3))+0.5,0,1))*(1-limit(1e5*((V(Z2_U2_N16667346) )-( 500E-3))+0.5,0,1)))*(1))
RZ17_INT Z17_YINT Z2_CLK 1
CZ17_INT Z2_CLK 0 1n
VZ2__U2_V2 Z2_U2_N16667112 0 5
RZ2__U2_R2 0 Z2_PS 10k
VZ2__U2_V5 Z2_U2_N16663404 0 5
BZ18_S_U2_S5 Z2_U2_N124395 0 I=(V(Z2_U2_N124395)-V(0))*exp(-20.7232658369+27.6310211159*(limit(((V(Z2_U2_RAMPDIS)-V(0))-0.2)/0.6,0,1))^2*(3-2*(limit(((V(Z2_U2_RAMPDIS)-V(0))-0.2)/0.6,0,1))))
RZ18_S_U2_S5 Z2_U2_RAMPDIS 0 1G
CZ2__U2_C1 0 Z2_U2_N124395 1n IC=0
BZ19_EOUT Z2_U2_N16666872 0 V=(limit(1e5*((V(Z2_U2_N16667046))-(1))+0.5,0,1)*(1))
BZ20_E_ABMGATE Z20_YINT 0 V=((1-(1-limit(1e5*((V(Z2_FAULT) )-( 500E-3))+0.5,0,1))*(1-limit(1e5*((V(Z2_CLK) )-( 500E-3))+0.5,0,1)))*(1))
RZ20_INT Z20_YINT Z2_U2_N16667168 1
CZ20_INT Z2_U2_N16667168 0 1n
VZ2__U2_V8 Z2_U2_N16666990 0 0
CZ2__U2_C3 0 Z2_U2_N16667046 1n IC=0
RZ2__U2_R1 Z2_PS_SYNCLOGIC Z2_PS 1
IZ2__U2_I1 Z2_U2_N16667112 Z2_U2_N16667046 DC 2.53m
BZ2_E_U2_GAIN1 Z2_BUCKRAMP 0 V=1 * V(Z2_U2_N124395)
VZ2__U2_V6 Z2_U2_N126085 0 5
VZ2__U2_V3 Z2_BOOSTRAMP Z2_U2_N16588429 30m
BZ21_E_ABMGATE Z21_YINT 0 V=((1-(1-limit(1e5*((V(Z2_FAULT) )-( 500E-3))+0.5,0,1))*(1-limit(1e5*((V(Z2_CLK) )-( 500E-3))+0.5,0,1)))*(1))
RZ21_INT Z21_YINT Z2_U2_RAMPDIS 1
CZ21_INT Z2_U2_RAMPDIS 0 1n
GZ2__U2_G2 Z2_U2_N126085 Z2_U2_N126109 OUT 0 0.84m
DZ2__U2_D4 Z2_U2_N124395 Z2_U2_N16663404 D_D1
DZ2__U2_D5 Z2_U2_N126109 Z2_U2_N126085 D_D1
BZ22_E_ABMGATE Z22_YINT 0 V=((1-(1-limit(1e5*((V(Z2_U2_N16666872) )-( 500E-3))+0.5,0,1))*(1-limit(1e5*((V(Z2_U2_N16666990) )-( 500E-3))+0.5,0,1)))*(1))
RZ22_INT Z22_YINT Z2_U2_N16667136 1
CZ22_INT Z2_U2_N16667136 0 1n
DZ2__U2_D6 Z2_U2_N16667046 Z2_U2_N16667112 D_D1
BZ23_S_U2_S6 Z2_U2_N126109 0 I=(V(Z2_U2_N126109)-V(0))*exp(-20.7232658369+27.6310211159*(limit(((V(Z2_U2_RAMPDIS)-V(0))-0.2)/0.6,0,1))^2*(3-2*(limit(((V(Z2_U2_RAMPDIS)-V(0))-0.2)/0.6,0,1))))
RZ23_S_U2_S6 Z2_U2_RAMPDIS 0 1G
RZ2__R1 Z1_POWERIN Z1_POWERIN 100
VZ2__U4_V1 Z2_U4_N137240 0 0.5
RZ2__U4_RZI Z2_U4_N138646 Z2_VCA 400k
BZ2_E_U4_GAIN1 Z2_U4_FB2 0 V=1 * V(Z1_FB)
DZ24_1 Z2_U4_N165156330 Z2_VVA Z24_DD
.model Z24_DD d is=1e-015 n=0.01 tt=1e-011
BZ2_E_U4_ABM1 Z2_U4_N165153511 0 V=((V(Z2_VVA))+(limit(1e5*(( 0.5)-(V(Z2_PS) ))+0.5,0,1)*limit(1e5*(( 0.5563)-(V(Z2_VVA) ))+0.5,0,1))*((0.55625)-(V(Z2_VVA))))
BZ25_S_U4_S1 Z2_VVA Z2_U4_N16542445 I=(V(Z2_VVA)-V(Z2_U4_N16542445))*exp(-0+-16.118095651*(limit(((V(Z2_PSOFF_N)-V(0))-0.2)/0.6,0,1))^2*(3-2*(limit(((V(Z2_PSOFF_N)-V(0))-0.2)/0.6,0,1))))
RZ25_S_U4_S1 Z2_PSOFF_N 0 1G
CZ2__U4_C5 0 Z2_U4_VVA_PROG 1n
GZ2__U4_G8 0 Z2_U4_VVA_ACT Z2_ISEN 0 5
BZ2_E_U4_GAIN2 Z2_U4_N16544672 0 V=1 * V(Z2_V2)
RZ2__U4_R6 Z2_U4_N165153511 Z2_U4_VVA_PROG 1
BZ26_S_U4_S2 Z2_VCA Z2_U4_N16544672 I=(V(Z2_VCA)-V(Z2_U4_N16544672))*exp(-0+-16.118095651*(limit(((V(Z2_PSOFF_N)-V(0))-0.2)/0.6,0,1))^2*(3-2*(limit(((V(Z2_PSOFF_N)-V(0))-0.2)/0.6,0,1))))
RZ26_S_U4_S2 Z2_PSOFF_N 0 1G
DZ27_1 Z2_VCA Z2_V2 Z27_DD
.model Z27_DD d is=1e-015 n=0.01 tt=1e-011
CZ2__U4_CCI 0 Z2_U4_N138646 20p IC=0
BZ2_G_U4_ABM3I1 0 Z2_VVA I=LIMIT(V(OUT)*10e-6*(V(Z2_VREF)-V(Z2_U4_FB2)),-2e-6,2e-6)
RZ2__U4_R8 0 Z2_VCA 1e9
RZ2__U4_R2 Z2_U4_N137240 Z2_U4_VVA_ACT 0.045
VZ2__U4_V3 Z2_U4_N165156330 0 500m
RZ2__U4_R7 0 Z2_VVA 1e9
DZ28_1 Z2_VVA Z2_ILIMIT Z28_DD
.model Z28_DD d is=1e-015 n=0.01 tt=1e-011
CZ2__U4_C7 0 Z2_VCA 10f
CZ2__U4_C6 0 Z2_VVA 10f
VZ2__U4_V4 Z2_U4_N16542445 0 0.55625
RZ2__U4_RZV Z2_U4_N134364 Z2_VVA 250k
VZ2__U4_V2 Z2_U4_VVA_PROG Z2_IAVG 0.5
CZ2__U4_CCV Z2_U4_N134364 0 40p IC=0.51
DZ29_1 Z2_V4 Z2_VCA Z29_DD
.model Z29_DD d is=1e-015 n=0.01 tt=1e-011
GZ2__U4_G5 0 Z2_VCA Z2_U4_VVA_PROG Z2_U4_VVA_ACT 20u
BZ2_E_ABM6 Z2_N16629194 0 V=(limit(1e5*((V(Z1_POWERIN) )-( 1.19))+0.5,0,1)*(1))
CZ2__U5_C9 0 Z2_U5_N6157516 1n
CZ2__U5_C16 0 Z2_U5_N16703225 1n
CZ2__U5_C5 0 Z2_U5_N6144664 1n
BZ2_E_U5_ABM13 Z2_U5_N167473441 0 V=((V(Z2_U5_N6157480))+limit(1e5*((V(Z2_U5_N6157480) )-( 4))+0.5,0,1)*((4)-(V(Z2_U5_N6157480))))
BZ30_E_ABM Z30_YINT 0 V=(limit(1e5*((V(Z2_U5_N6105639) )-( V(Z1_FB)))+0.5,0,1)*(1))
RZ30_1 Z30_YINT Z2_U5_N6097544 1
CZ30_1 Z2_U5_N6097544 0 1n
RZ2__U5_R11 Z2_U5_N6144180 Z2_U5_N6144664 2k
DZ2__U5_D6 Z2_U5_N16754558 Z2_U5_N16754622 D_D1
VZ2__U5_V10 Z2_U5_N16705913 0 1.9
BZ2_E_U5_GAIN1 Z2_U5_N6165616 0 V=1 * V(OUT)
VZ2__U5_V1 Z2_VREF 0 0.5
CZ2__U5_C15 0 Z2_U5_N16699386 1n
BZ2_E_U5_GAIN2 Z2_U5_N6166485 0 V=1 * V(Z2_VIN_BUF)
BZ31_E_ABM Z31_YINT 0 V=(limit(1e5*((V(Z2_VIN_BUF) )-( V(Z2_U5_N6059017)))+0.5,0,1)*(1))
RZ31_1 Z31_YINT Z2_U5_N6062862 1
CZ31_1 Z2_U5_N6062862 0 1n
BZ32_E_ABMGATE Z32_YINT 0 V=((limit(1e5*((V(Z2_U5_N6063555) )-( 500E-3))+0.5,0,1)*limit(1e5*((V(Z2_U5_N16727053) )-( 500E-3))+0.5,0,1))*(1))
RZ32_INT Z32_YINT Z2_U5_FAULT_BAR 1
CZ32_INT Z2_U5_FAULT_BAR 0 1n
RZ2__U5_R18 Z2_U5_N167473441 Z2_U5_VOUTLIMIT 1
BZ33_S_U5_S4 Z2_U5_N16754558 0 I=(V(Z2_U5_N16754558)-V(0))*exp(6.90775527898+-23.0258509299*(limit(((V(Z2_U5_DELAYENABLE)-V(0))-0.2)/0.3,0,1))^2*(3-2*(limit(((V(Z2_U5_DELAYENABLE)-V(0))-0.2)/0.3,0,1))))
RZ33_S_U5_S4 Z2_U5_DELAYENABLE 0 1G
BZ34_E_ABM Z34_YINT 0 V=(limit(1e5*((V(Z2_U5_N6126241) )-( V(Z2_VVA)))+0.5,0,1)*(1))
RZ34_1 Z34_YINT Z2_U5_N6123789 1
CZ34_1 Z2_U5_N6123789 0 1n
BZ35_E_ABMGATE Z35_YINT 0 V=((limit(1e5*((V(Z2_U5_N6062862) )-( 500E-3))+0.5,0,1)*limit(1e5*((V(Z2_U5_N6063005) )-( 500E-3))+0.5,0,1))*(1))
RZ35_INT Z35_YINT Z2_U5_N6063555 1
CZ35_INT Z2_U5_N6063555 0 1n
BZ2_E_U5_ABM5 Z2_U5_N6157610 0 V=V(Z2_U5_N6165616)*3 + 0.4
VZ2__U5_V9 Z2_U5_N16697981 0 -1.9
BZ2_E_U5_ABM17 Z2_U5_N16714820 0 V=((V(Z2_U5_VOUTLIMIT))+limit(1e5*((V(Z2_U5_DELAYENABLE) )-( 0.5))+0.5,0,1)*((V(Z2_U5_N16707701))-(V(Z2_U5_VOUTLIMIT))))
RZ2__U5_R24 Z2_U5_N16714820 Z2_U5_FINALVOUT 1
BZ36_E_ABM Z36_YINT 0 V=(limit(1e5*((V(Z1_FB) )-( V(Z2_U5_N6096022)))+0.5,0,1)*(1))
RZ36_1 Z36_YINT Z2_U5_N6101882 1
CZ36_1 Z2_U5_N6101882 0 1n
BZ37_E_ABM Z37_YINT 0 V=(limit(1e5*((V(Z1_POWERIN) )-( V(Z2_U5_N6059017)))+0.5,0,1)*(1))
RZ37_1 Z37_YINT Z2_U5_N6063005 1
CZ37_1 Z2_U5_N6063005 0 1n
CZ2__U5_C12 0 Z2_U5_VOUTLIMIT 1n
CZ2__U5_C18 0 Z2_U5_FINALVOUT 1n
BZ38_GQ 0 Z38_QINT I=(((limit(1e5*((V(Z2_U5_N6097544))-(0.5))+0.5,0,1)*(5)))+limit(1e5*((V(Z2_U5_N6101882) )-( 0.5))+0.5,0,1)*((-5)-((limit(1e5*((V(Z2_U5_N6097544))-(0.5))+0.5,0,1)*(5)))))
CZ38_Qint Z38_QINT 0 1n
RZ38_Qint Z38_QINT 0 1000MEG
DZ38__D10 Z38_QINT Z38_MY5 D_D1
VZ38_1 Z38_MY5 0 1
DZ38__D11 Z38_MYVSS Z38_QINT D_D1
VZ38_2 Z38_MYVSS 0 0
EZ38_Q Z38_QQQ 0 Z38_QINT 0 1
BZ39_E_ABMGATE Z39_YINT 0 V=(limit(1e5*((V(Z38_QQQ) )-( 0.5))+0.5,0,1)*(1))
RZ39_INT Z39_YINT Z38_QQQD1 1
CZ39_INT Z38_QQQD1 0 1n
RZ38_Qq Z38_QQQD1 Z2_U5_N6104039 1
BZ38_EQb Z38_QBR 0 V=((1-limit(1e5*((V(Z2_U5_N6104039) )-( 0.5))+0.5,0,1))*(1))
RZ38_Qb Z38_QBR Z2_U5_N6100335 1
CZ38_dummy1 Z2_U5_N6104039 0 1n
CZ38_dummy2 Z2_U5_N6100335 0 1n
.IC V(Z38_QINT)=0
BZ2_E_U5_ABM3 Z2_V2 0 V=V(Z2_V3)*0.8
VZ2__U5_V8 Z2_U5_N16754622 0 1.1
RZ2__U5_R12 Z2_U5_N6157414 Z2_U5_N6157424 1
BZ40_E_ABMGATE Z40_YINT 0 V=((limit(1e5*((V(Z2_U5_N16692251) )-( 500E-3))+0.5,0,1)*limit(1e5*((V(Z2_U5_N16691319) )-( 500E-3))+0.5,0,1))*(1))
RZ40_INT Z40_YINT Z2_U5_DELAYENABLE 1
CZ40_INT Z2_U5_DELAYENABLE 0 1n
BZ2_E_U5_ABM16 Z2_U5_N166917621 0 V=(limit(1e5*((V(OUT) )-( 0.5))+0.5,0,1)*(1))
BZ2_E_U5_ABM14 Z2_U5_N167226131 0 V=((V(Z2_U5_N6157516))+limit(1e5*((V(Z2_U5_N6157516) )-( 4))+0.5,0,1)*((4)-(V(Z2_U5_N6157516))))
BZ41_S_U5_S1 Z1_PG 0 I=(V(Z1_PG)-V(0))*exp(-8.2940496401+-9.52879410309*(limit(((V(Z2_U5_N6144664)-V(0))-0.2)/0.6,0,1))^2*(3-2*(limit(((V(Z2_U5_N6144664)-V(0))-0.2)/0.6,0,1))))
RZ41_S_U5_S1 Z2_U5_N6144664 0 1G
BZ2_E_U5_ABM8 Z2_ILIMIT 0 V=V(Z2_U5_N6162282)*0.225 + 0.5
DZ2__U5_D8 Z2_U5_N6144180 Z2_U5_N6144664 D_D1
RZ2__U5_R20 Z2_U5_N166917621 Z2_U5_N16692251 1
RZ2__U5_R23 Z2_U5_N16708681 Z2_U5_N16707701 1
BZ2_E_U5_ABM4 Z2_V4 0 V=V(Z2_VIN_BUF)*0.0167
RZ2__U5_R25 Z2_U5_N167226131 Z2_U5_VINLIMIT 1
CZ2__U5_C6 0 Z2_U5_N6157424 1n
BZ2_E_U5_SUM1 Z2_U5_N16697749 0 V=V(Z2_U5_N16697981)+V(Z2_U5_VOUTLIMIT)
CZ2__U5_C20 0 Z2_U5_N16727053 1n
BZ2_E_U5_ABM10 Z2_U5_N61617881 0 V=((V(Z2_U5_N6157424))+limit(1e5*(( 0.4)-(V(Z2_U5_N6157424) ))+0.5,0,1)*((0.4)-(V(Z2_U5_N6157424))))
CZ2__U5_C17 0 Z2_U5_N16707701 1n
BZ42_E_ABMGATE Z42_YINT 0 V=((1-(1-limit(1e5*((V(Z2_PS) )-( 500E-3))+0.5,0,1))*(1-limit(1e5*((V(Z2_U5_N6104039) )-( 500E-3))+0.5,0,1)))*(1))
RZ42_INT Z42_YINT Z2_PSOFF_N 1
CZ42_INT Z2_PSOFF_N 0 1n
RZ2__U5_R26 Z2_ENLOGIC Z2_U5_N16727053 86.4k
CZ2__U5_C14 0 Z2_U5_N16692251 1n
VZ2__U5_V2 Z2_U5_N6059017 0 1.5
RZ2__U5_R14 Z2_U5_N6157610 Z2_U5_N6157480 1
BZ43_E_ABMGATE Z43_YINT 0 V=((1-limit(1e5*((V(Z2_FAULT) )-( 500E-3))+0.5,0,1))*(1))
RZ43_INT Z43_YINT Z2_U5_N16691319 1
CZ43_INT Z2_U5_N16691319 0 1n
RZ2__U5_R16 Z2_U5_N61617881 Z2_U5_N6162282 1
CZ2__U5_C19 0 Z2_U5_VINLIMIT 1n
BZ2_E_U5_ABM15 Z2_U5_N16754764 0 V=((V(Z2_U5_N16754558))+limit(1e5*((V(Z2_U5_N16754558) )-( 1))+0.5,0,1)*((1)-(V(Z2_U5_N16754558))))
BZ44_E_ABMGATE Z44_YINT 0 V=((1-limit(1e5*((V(Z2_U5_FAULT_BAR) )-( 500E-3))+0.5,0,1))*(1))
RZ44_INT Z44_YINT Z2_FAULT 1
CZ44_INT Z2_FAULT 0 1n
BZ2_E_U5_ABM6 Z2_U5_N6157234 0 V=V(Z2_U5_N6166485)*7 - 12.1
VZ2__U5_V5 Z2_U5_N6105639 0 0.5
VZ2__U5_V3 Z2_U5_N6096022 0 0.51
BZ45_E_ABMGATE Z45_YINT 0 V=((limit(1e5*((V(Z2_U5_N6123789) )-( 500E-3))+0.5,0,1)*limit(1e5*((V(Z2_U5_N6123654) )-( 500E-3))+0.5,0,1)*limit(1e5*((V(Z2_U5_FAULT_BAR) )-( 500E-3))+0.5,0,1))*(1))
RZ45_INT Z45_YINT Z2_U5_N6144180 1
CZ45_INT Z2_U5_N6144180 0 1n
CZ2__U5_C8 0 Z2_U5_N6157480 1n
DZ2__U5_D7 Z2_U5_N16727053 Z2_ENLOGIC D_D1
VZ2__U5_V7 Z2_U5_N6123425 0 0.1
RZ2__U5_R19 Z2_U5_N16754764 Z2_U5_GAINFACTOR 1
RZ2__U5_R10 0 Z2_U5_N6100335 10k
CZ2__U5_C10 0 Z2_U5_N6162282 1n
CZ2__U5_C3 0 Z2_U5_N16754558 1n IC=0
BZ2_E_U5_ABM12 Z2_U5_N6126241 0 V=V(Z2_ILIMIT) - 10e-3
CZ2__U5_C13 0 Z2_U5_GAINFACTOR 1n
BZ2_E_U5_ABM9 Z2_U5_N6157414 0 V=((V(Z2_U5_VINLIMIT))+limit(1e5*(( V(Z2_U5_VINLIMIT))-(V(Z2_U5_FINALVOUT) ))+0.5,0,1)*((V(Z2_U5_FINALVOUT))-(V(Z2_U5_VINLIMIT))))
RZ2__U5_R15 Z2_U5_N6157234 Z2_U5_N6157516 1
RZ2__U5_R22 Z2_U5_N16703504 Z2_U5_N16703225 1
BZ46_E_ABM Z46_YINT 0 V=(limit(1e5*((V(Z1_FB) )-( V(Z2_U5_N6123425)))+0.5,0,1)*(1))
RZ46_1 Z46_YINT Z2_U5_N6123654 1
CZ46_1 Z2_U5_N6123654 0 1n
IZ2__U5_I1 Z2_U5_N16754622 Z2_U5_N16754558 DC 2.5u
BZ2_E_U5_MULT2 Z2_U5_N16703504 0 V=V(Z2_U5_GAINFACTOR)*V(Z2_U5_N16699386)
BZ2_E_U5_SUM2 Z2_U5_N16708681 0 V=V(Z2_U5_N16705913)+V(Z2_U5_N16703225)
BZ2_E_U5_ABM2 Z2_V3 0 V=(V(OUT)+V(Z2_VIN_BUF))/3
RZ2__U5_R21 Z2_U5_N16697749 Z2_U5_N16699386 1
BZ47_E_ABMGATE1 Z47_YINT1 0 V=(limit(1e5*((V(Z2_U3_N16710240) )-( 0.5))+0.5,0,1)*(1))
RZ47_INT Z47_YINT1 Z47_YINT2 1
CZ47_INT Z47_YINT2 0 26n
BZ47_E_ABMGATE2 Z47_YINT3 0 V=(limit(1e5*((V(Z47_YINT2) )-( 0.5))+0.5,0,1)*(1))
RZ47_INT2 Z47_YINT3 Z2_U3_N16710232 1
CZ47_INT2 Z2_U3_N16710232 0 1n
BZ48_S_U3_S2 Z2_U3_N149923 Z1_SW1 I=(V(Z2_U3_N149923)-V(Z1_SW1))*exp(-13.815510558+16.9166033472*(limit(((V(Z2_U3_BUCKDRV_PRE)-V(0))-0.2)/0.6,0,1))^2*(3-2*(limit(((V(Z2_U3_BUCKDRV_PRE)-V(0))-0.2)/0.6,0,1))))
RZ48_S_U3_S2 Z2_U3_BUCKDRV_PRE 0 1G
CZ2__U3_C10 0 Z2_U3_N16715337 100p
BZ49_S_U3_S4 OUT Z1_SW2 I=(V(OUT)-V(Z1_SW2))*exp(-13.815510558+16.9166033472*(limit(((V(Z2_U3_N176320)-V(0))-0.2)/0.6,0,1))^2*(3-2*(limit(((V(Z2_U3_N176320)-V(0))-0.2)/0.6,0,1))))
RZ49_S_U3_S4 Z2_U3_N176320 0 1G
BZ50_E_ABMGATE Z50_YINT 0 V=((limit(1e5*((V(Z2_U3_N16705153) )-( 500E-3))+0.5,0,1)*limit(1e5*((V(Z2_U3_N16705010) )-( 500E-3))+0.5,0,1))*(1))
RZ50_INT Z50_YINT Z2_U3_N16705859 1
CZ50_INT Z2_U3_N16705859 0 1n
CZ2__U3_C7 0 Z2_U3_N148451 20p
BZ51_E_ABMGATE Z51_YINT 0 V=((limit(1e5*((V(Z2_U3_BUCKDRV_PRE) )-( 500E-3))+0.5,0,1)*limit(1e5*((V(Z2_U3_N162195) )-( 500E-3))+0.5,0,1))*(1))
RZ51_INT Z51_YINT Z2_U3_N167831 1
CZ51_INT Z2_U3_N167831 0 1n
BZ52_S_U3_S1 Z2_U3_N148856 Z2_U3_N148451 I=(V(Z2_U3_N148856)-V(Z2_U3_N148451))*exp(-11.512925465+7.60090245954*(limit(((V(Z2_U3_N167831)-V(0))-0.25)/0.5,0,1))^2*(3-2*(limit(((V(Z2_U3_N167831)-V(0))-0.25)/0.5,0,1))))
RZ52_S_U3_S1 Z2_U3_N167831 0 1G
BZ53_E_ABMGATE Z53_YINT 0 V=((1-limit(1e5*((V(Z2_U3_N166627) )-( 500E-3))+0.5,0,1))*(1))
RZ53_INT Z53_YINT Z2_U3_N16710240 1
CZ53_INT Z2_U3_N16710240 0 1n
HZ54__U3_H1 Z2_U3_N148856 0 VZ54_H_U3_H1 1
VZ54_H_U3_H1 Z1_POWERIN Z2_U3_N149923 0V
BZ55_E_ABMGATE Z55_YINT 0 V=((limit(1e5*((V(Z2_U3_N166627) )-( 500E-3))+0.5,0,1)*limit(1e5*((V(Z2_U3_N16709141) )-( 500E-3))+0.5,0,1))*(1))
RZ55_INT Z55_YINT Z2_U3_N176320 1
CZ55_INT Z2_U3_N176320 0 1n
RZ2__U3_R3 Z2_U3_N16713177 Z2_U3_N16715337 50
BZ56_E_ABMGATE1 Z56_YINT1 0 V=(limit(1e5*((V(Z2_U3_N166627) )-( 0.5))+0.5,0,1)*(1))
RZ56_INT Z56_YINT1 Z56_YINT2 1
CZ56_INT Z56_YINT2 0 26n
BZ56_E_ABMGATE2 Z56_YINT3 0 V=(limit(1e5*((V(Z56_YINT2) )-( 0.5))+0.5,0,1)*(1))
RZ56_INT2 Z56_YINT3 Z2_U3_N16709141 1
CZ56_INT2 Z2_U3_N16709141 0 1n
RZ2__U3_R2 Z2_U3_N1571031 Z2_ISEN 1
BZ57_S_U3_S5 Z1_SW2 0 I=(V(Z1_SW2)-V(0))*exp(-13.815510558+16.4747705949*(limit(((V(Z2_U3_N178130)-V(0))-0.2)/0.6,0,1))^2*(3-2*(limit(((V(Z2_U3_N178130)-V(0))-0.2)/0.6,0,1))))
RZ57_S_U3_S5 Z2_U3_N178130 0 1G
BZ58_E_ABMGATE1 Z58_YINT1 0 V=(limit(1e5*((V(Z2_U3_N16713177) )-( 0.5))+0.5,0,1)*(1))
RZ58_INT Z58_YINT1 Z58_YINT2 1
CZ58_INT Z58_YINT2 0 6.5n
BZ58_E_ABMGATE2 Z58_YINT3 0 V=(limit(1e5*((V(Z58_YINT2) )-( 0.5))+0.5,0,1)*(1))
RZ58_INT2 Z58_YINT3 Z2_U3_BUCKDRV_PRE 1
CZ58_INT2 Z2_U3_BUCKDRV_PRE 0 1n
BZ59_E_ABMGATE Z59_YINT 0 V=((limit(1e5*((V(Z2_U3_N162195) )-( 500E-3))+0.5,0,1)*limit(1e5*((V(Z2_U3_N16706290) )-( 500E-3))+0.5,0,1))*(1))
RZ59_INT Z59_YINT Z2_U3_N16713177 1
CZ59_INT Z2_U3_N16713177 0 1n
CZ2__U3_C9 0 Z2_ISEN 1n
BZ60_E_ABMGATE Z60_YINT 0 V=((limit(1e5*((V(Z2_BUCKDRV) )-( 500E-3))+0.5,0,1)*limit(1e5*((V(Z2_U3_FAULT_BAR) )-( 500E-3))+0.5,0,1))*(1))
RZ60_INT Z60_YINT Z2_U3_N162195 1
CZ60_INT Z2_U3_N162195 0 1n
BZ61_E_ABMGATE Z61_YINT 0 V=((1-limit(1e5*((V(Z2_FAULT) )-( 500E-3))+0.5,0,1))*(1))
RZ61_INT Z61_YINT Z2_U3_FAULT_BAR 1
CZ61_INT Z2_U3_FAULT_BAR 0 1n
BZ62_E_ABMGATE Z62_YINT 0 V=((limit(1e5*((V(Z2_U3_FAULT_BAR) )-( 500E-3))+0.5,0,1)*limit(1e5*((V(Z2_BOOSTDRV) )-( 500E-3))+0.5,0,1))*(1))
RZ62_INT Z62_YINT Z2_U3_N166627 1
CZ62_INT Z2_U3_N166627 0 1n
DZ2__U3_D1 Z1_SW1 Z2_U3_N149923 D_D1
BZ63_E_ABMGATE1 Z63_YINT1 0 V=(limit(1e5*((V(Z2_U3_N162195) )-( 0.5))+0.5,0,1)*(1))
RZ63_INT Z63_YINT1 Z63_YINT2 1
CZ63_INT Z63_YINT2 0 19.5n
BZ63_E_ABMGATE2 Z63_YINT3 0 V=(limit(1e5*((V(Z63_YINT2) )-( 0.5))+0.5,0,1)*(1))
RZ63_INT2 Z63_YINT3 Z2_U3_N16706290 1
CZ63_INT2 Z2_U3_N16706290 0 1n
BZ64_E_ABMGATE Z64_YINT 0 V=((limit(1e5*((V(Z2_U3_N16710738) )-( 500E-3))+0.5,0,1)*limit(1e5*((V(Z2_U3_FAULT_BAR) )-( 500E-3))+0.5,0,1)*limit(1e5*((V(Z2_PSOFF_N) )-( 500E-3))+0.5,0,1))*(1))
RZ64_INT Z64_YINT Z2_U3_N178130 1
CZ64_INT Z2_U3_N178130 0 1n
BZ65_E_ABMGATE Z65_YINT 0 V=((1-limit(1e5*((V(Z2_U3_N162195) )-( 500E-3))+0.5,0,1))*(1))
RZ65_INT Z65_YINT Z2_U3_N16705153 1
CZ65_INT Z2_U3_N16705153 0 1n
BZ66_E_ABMGATE1 Z66_YINT1 0 V=(limit(1e5*((V(Z2_U3_N16705153) )-( 0.5))+0.5,0,1)*(1))
RZ66_INT Z66_YINT1 Z66_YINT2 1
CZ66_INT Z66_YINT2 0 26n
BZ66_E_ABMGATE2 Z66_YINT3 0 V=(limit(1e5*((V(Z66_YINT2) )-( 0.5))+0.5,0,1)*(1))
RZ66_INT2 Z66_YINT3 Z2_U3_N16705010 1
CZ66_INT2 Z2_U3_N16705010 0 1n
BZ67_E_ABMGATE Z67_YINT 0 V=((limit(1e5*((V(Z2_U3_N16705859) )-( 500E-3))+0.5,0,1)*limit(1e5*((V(Z2_PSOFF_N) )-( 500E-3))+0.5,0,1)*limit(1e5*((V(Z2_U3_FAULT_BAR) )-( 500E-3))+0.5,0,1))*(1))
RZ67_INT Z67_YINT Z2_U3_N179660 1
CZ67_INT Z2_U3_N179660 0 1n
DZ2__U3_D3 Z1_SW2 OUT D_D1
BZ2_E_U3_ABM1 Z2_U3_N1571031 0 V=((1-limit(1e5*((V(Z2_FAULT) )-( 0.5))+0.5,0,1))*(V(Z2_U3_N148451)))
BZ68_E_ABMGATE Z68_YINT 0 V=((limit(1e5*((V(Z2_U3_N16710240) )-( 500E-3))+0.5,0,1)*limit(1e5*((V(Z2_U3_N16710232) )-( 500E-3))+0.5,0,1))*(1))
RZ68_INT Z68_YINT Z2_U3_N16710738 1
CZ68_INT Z2_U3_N16710738 0 1n
BZ69_S_U3_S3 Z1_SW1 0 I=(V(Z1_SW1)-V(0))*exp(-13.815510558+16.4747705949*(limit(((V(Z2_U3_N179660)-V(0))-0.2)/0.6,0,1))^2*(3-2*(limit(((V(Z2_U3_N179660)-V(0))-0.2)/0.6,0,1))))
RZ69_S_U3_S3 Z2_U3_N179660 0 1G
DZ2__U3_D5 Z2_U3_N16715337 Z2_U3_N16713177 D_D1
DZ2__U3_D4 0 Z1_SW2 D_D1
DZ2__U3_D2 0 Z1_SW1 D_D1
RZ2__R9 Z2_N16629194 Z2_PS_SYNCLOGIC 1
CZ2__C8 0 Z2_PS_SYNCLOGIC 1n
LZ1_1 Z1_SW1 Z1_SW2 1u
CZ1_IN Z1_POWERIN RET 20u
CZ1_BYP Z1_POWERIN SENSE_RET 100n
CZ1_OUT OUT RET 88u
RZ1_FBTOP OUT Z1_FB 1meg
RZ1_FBBOT Z1_FB SENSE_RET 180k
RZ1_FF OUT Z1_FF 68k
CZ1_FF Z1_FF Z1_FB 4.7p
RTEST OUT RET 330
.ENDS TPS63020_NODE13
